ADE simulation setup
Run mode: Single Run, Sweeps and Corners
Tests:
  Diff_Amp:diff_req:1: Diff_Amp/diff_req/schematic, simulator spectre
Global variables:
  LIN = 1u
  RD = 9k
  WIN = 23*LIN
  LCS = LIN
  WCS = 2*WIN
